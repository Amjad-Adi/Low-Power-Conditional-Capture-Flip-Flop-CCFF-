*** SPICE deck for cell CCFF{lay} from library CCFF_22nmV3
*** Created on Tue Jan 27, 2026 02:02:41
*** Last revised on Thu Feb 12, 2026 22:21:03
*** Written on Thu Feb 12, 2026 22:22:34 by Electric VLSI Design System, version 9.07
*** Layout tech: mocmos, foundry MOSIS
*** UC SPICE *** , MIN_RESIST 4.0, MIN_CAPAC 0.1FF

*** TOP LEVEL CELL: CCFF{lay}
Mnmos@0 net@5 net@13 gnd gnd NMOS L=0.022U W=1.65U AS=0.071P AD=0.192P PS=2.377U PD=5.856U
Mnmos@1 net@13 net@5 gnd gnd NMOS L=0.022U W=0.055U AS=0.071P AD=0.17P PS=2.377U PD=5.069U
Mnmos@2 net@105 net@91 gnd gnd NMOS L=0.022U W=1.65U AS=0.071P AD=0.192P PS=2.377U PD=5.856U
Mnmos@3 net@91 net@105 gnd gnd NMOS L=0.022U W=0.055U AS=0.071P AD=0.17P PS=2.377U PD=5.069U
Mnmos@4 net@133 net@433 net@13 gnd NMOS L=0.022U W=3.3U AS=0.17P AD=0.055P PS=5.069U PD=3.36U
Mnmos@5 net@562 A net@133 gnd NMOS L=0.022U W=3.3U AS=0.055P AD=0.254P PS=3.36U PD=6.754U
Mnmos@6 net@193 QB gnd gnd NMOS L=0.022U W=0.055U AS=0.071P AD=0.011P PS=2.377U PD=0.385U
Mnmos@7 gnd Buffer net@193 gnd NMOS L=0.022U W=0.055U AS=0.011P AD=0.071P PS=0.385U PD=2.377U
Mnmos@8 gnd net@105 Q gnd NMOS L=0.022U W=1.65U AS=0.233P AD=0.071P PS=7.065U PD=2.377U
Mnmos@9 net@105 Q QB gnd NMOS L=0.022U W=1.65U AS=0.236P AD=0.192P PS=7.065U PD=5.856U
Mnmos@10 Q QB net@5 gnd NMOS L=0.022U W=1.65U AS=0.192P AD=0.233P PS=5.856U PD=7.065U
Mnmos@11 QB net@5 gnd gnd NMOS L=0.022U W=1.65U AS=0.071P AD=0.236P PS=2.377U PD=7.065U
Mnmos@12 net@433 Q gnd gnd NMOS L=0.022U W=0.055U AS=0.071P AD=0.012P PS=2.377U PD=0.389U
Mnmos@13 gnd Buffer net@433 gnd NMOS L=0.022U W=0.055U AS=0.012P AD=0.071P PS=0.389U PD=2.377U
Mnmos@14 net@538 net@2102 net@91 gnd NMOS L=0.022U W=3.3U AS=0.17P AD=0.064P PS=5.069U PD=3.355U
Mnmos@15 net@562 net@193 net@538 gnd NMOS L=0.022U W=3.3U AS=0.064P AD=0.254P PS=3.355U PD=6.754U
Mnmos@16 net@562 CK gnd gnd NMOS L=0.022U W=3.3U AS=0.071P AD=0.254P PS=2.377U PD=6.754U
Mnmos@17 net@2102 A gnd gnd NMOS L=0.022U W=0.055U AS=0.071P AD=0.008P PS=2.377U PD=0.363U
Mnmos@18 Buffer net@789 gnd gnd NMOS L=0.055U W=0.055U AS=0.071P AD=0.007P PS=2.377U PD=0.358U
Mnmos@19 net@789 CK gnd gnd NMOS L=0.22U W=0.055U AS=0.071P AD=0.007P PS=2.377U PD=0.352U
Mnmos@21 nmos@21_diff-bottom nmos@21_poly-left nmos@21_diff-top gnd nmos L=1.32U W=1.32U AS=0.044P AD=0.044P PS=2.706U PD=2.706U
Mnmos@22 nmos@22_diff-bottom nmos@22_poly-left nmos@22_diff-top gnd nmos L=1.32U W=1.1U AS=0.036P AD=0.036P PS=2.266U PD=2.266U
Mpmos@0 net@5 net@13 vdd vdd PMOS L=0.022U W=5.28U AS=0.18P AD=0.192P PS=5.554U PD=5.856U
Mpmos@1 net@13 net@5 vdd vdd PMOS L=0.022U W=0.176U AS=0.18P AD=0.17P PS=5.554U PD=5.069U
Mpmos@2 net@13 CK vdd vdd PMOS L=0.022U W=3.52U AS=0.18P AD=0.17P PS=5.554U PD=5.069U
Mpmos@3 vdd CK net@91 vdd PMOS L=0.022U W=3.52U AS=0.17P AD=0.18P PS=5.069U PD=5.554U
Mpmos@4 net@105 net@91 vdd vdd PMOS L=0.022U W=5.28U AS=0.18P AD=0.192P PS=5.554U PD=5.856U
Mpmos@5 net@91 net@105 vdd vdd PMOS L=0.022U W=0.176U AS=0.18P AD=0.17P PS=5.554U PD=5.069U
Mpmos@6 net@193 QB net@144 vdd PMOS L=0.022U W=0.352U AS=0.006P AD=0.011P PS=0.413U PD=0.385U
Mpmos@7 net@144 Buffer vdd vdd PMOS L=0.022U W=0.352U AS=0.18P AD=0.006P PS=5.554U PD=0.413U
Mpmos@8 net@13 Q QB vdd PMOS L=0.022U W=5.28U AS=0.236P AD=0.17P PS=7.065U PD=5.069U
Mpmos@9 Q QB net@91 vdd PMOS L=0.022U W=5.28U AS=0.17P AD=0.233P PS=5.069U PD=7.065U
Mpmos@10 QB net@91 vdd vdd PMOS L=0.022U W=5.28U AS=0.18P AD=0.236P PS=5.554U PD=7.065U
Mpmos@11 net@433 Q net@430 vdd PMOS L=0.022U W=0.352U AS=0.006P AD=0.012P PS=0.413U PD=0.389U
Mpmos@12 net@430 Buffer vdd vdd PMOS L=0.022U W=0.352U AS=0.18P AD=0.006P PS=5.554U PD=0.413U
Mpmos@13 net@2102 A vdd vdd PMOS L=0.022U W=0.176U AS=0.18P AD=0.008P PS=5.554U PD=0.363U
Mpmos@14 net@789 CK vdd vdd PMOS L=0.22U W=0.176U AS=0.18P AD=0.007P PS=5.554U PD=0.352U
Mpmos@15 Buffer net@789 vdd vdd PMOS L=0.055U W=0.176U AS=0.18P AD=0.007P PS=5.554U PD=0.358U
Mpmos@16 vdd net@13 Q vdd PMOS L=0.022U W=5.28U AS=0.233P AD=0.18P PS=7.065U PD=5.554U
.END
